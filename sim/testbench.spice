* Oscillating Bones Teshbench

.include "pdk_lib.spice"

* Power supply
V1 VGND 0 0
V2 VDPWR VGND 1.8
V3 VAPWR VGND 3.3
V4 clk 0 0
V5 ena VGND 1.8
V6 rst_n VGND 1.8

.include "tt_um_oscillating_bones.spice"

* Instance line is generated from the .subckt header by gen_dut_inst.py,
* because magic's port order is not stable across tool versions.
.include "dut_inst.spice"

.tran 50p 80n

.control
run
plot "uo_out[0]" "ua[0]" "uo_out[1]"+4 "uo_out[2]"+6 "uo_out[3]"+8
meas tran tdiff TRIG "uo_out[0]" VAL=1.7 RISE=2 TARG "uo_out[0]" VAL=1.7 RISE=3
let freq_mhz = (1 / (tdiff) / 1e6)
print freq_mhz
.endc
.end

.end
